* NeuroChain U1: impedance of Utah Pt, in saline (ideal capacitor)
* Generated by neurochain.frontend.spice; do not edit by hand.
.options temp=37 tnom=27
Itest 0 tissue dc 0 ac 1
* Utah Pt, in saline (ideal capacitor): Rs, then Rct in parallel with the double layer
Rs tissue iface 7300
Rct iface 0 4.6e+09
Cdl iface 0 7.31188817e-10
.control
set wr_singlescale
set wr_vecnames
ac dec 20 1 10000
wrdata impedance.spice.txt v(tissue)
quit
.endc
.end
