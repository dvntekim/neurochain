* NeuroChain U1: impedance of Utah Pt, in saline
* Generated by neurochain.frontend.spice; do not edit by hand.
.options temp=37 tnom=27
Itest 0 tissue dc 0 ac 1
* Utah Pt, in saline: Rs, then Rct in parallel with the double layer
Rs tissue iface 7300
Rct iface 0 4.6e+09
* Constant-phase element Q=7.2e-09 n=0.74 as an RC ladder
Rlow iface 0 2.88859833e+10
Chigh iface 0 5.19267747e-11
Rb0 iface b0 2.2144697e+10
Cb0 b0 0 7.18704541e-09
Rb1 iface b1 9.4464742e+09
Cb1 b1 0 5.32783037e-09
Rb2 iface b2 4.02967242e+09
Cb2 b2 0 3.94957522e-09
Rb3 iface b3 1.71897572e+09
Cb3 b3 0 2.92786056e-09
Rb4 iface b4 733279836
Cb4 b4 0 2.17045302e-09
Rb5 iface b5 312802159
Cb5 b5 0 1.60897905e-09
Rb6 iface b6 133434995
Cb6 b6 0 1.19275265e-09
Rb7 iface b7 56920635.8
Cb7 b7 0 8.84199753e-10
Rb8 iface b8 24281177.4
Cb8 b8 0 6.55466332e-10
Rb9 iface b9 10357853
Cb9 b9 0 4.85903905e-10
Rb10 iface b10 4418447.94
Cb10 b10 0 3.60205541e-10
Rb11 iface b11 1884819.4
Cb11 b11 0 2.67024056e-10
Rb12 iface b12 804025.352
Cb12 b12 0 1.97947668e-10
Rb13 iface b13 342980.748
Cb13 b13 0 1.46740633e-10
Rb14 iface b14 146308.562
Cb14 b14 0 1.08780334e-10
Rb15 iface b15 62412.2361
Cb15 b15 0 8.06399758e-11
Rb16 iface b16 26623.7816
Cb16 b16 0 5.977924e-11
Rb17 iface b17 11357.16
Cb17 b17 0 4.43149628e-11
Rb18 iface b18 4844.73183
Cb18 b18 0 3.28511358e-11
Rb19 iface b19 2066.66337
Cb19 b19 0 2.43528834e-11
Rb20 iface b20 881.596267
Cb20 b20 0 1.80530419e-11
.control
set wr_singlescale
set wr_vecnames
ac dec 20 1 10000
wrdata impedance.spice.txt v(tissue)
quit
.endc
.end
